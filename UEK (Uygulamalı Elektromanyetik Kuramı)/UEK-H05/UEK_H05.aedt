# Ansys Electronics Desktop project, version 2018.0
materials:
  vacuum: permittivity=1
  Rogers RT/duroid 5880 (tm): permittivity=2.2 dielectric_loss_tangent=0.0009
  pec: conductivity=1e+030
  Breast_skin: permittivity=17.7 dielectric_loss_tangent=0.93 delta_H_freq=33000000000
  Breast_fat: permittivity=3.4 dielectric_loss_tangent=0.16 delta_H_freq=33000000000
  Breast_fibro: permittivity=16 dielectric_loss_tangent=0.94 delta_H_freq=33000000000
  Tumor: permittivity=18 dielectric_loss_tangent=1.05 delta_H_freq=33000000000

design HFSSDesign1 (HFSS, DrivenModal, model units mm)
variables:
  SL = 4.7mm
  SW = 4.7mm
  SH = 0.508mm
  PL = 2.75mm
  PW = 3.1mm
  MW = 0.2mm
  inL = 0.2mm
  inW = 0.15mm
  dist = 12mm
  breast_offset = 1mm
  breast_rad = 10mm
  areola_dist = breast_rad-0.5mm
  areola_rad = 1mm
  Tx = 0mm
  Ty = 0mm
  Tz = 5mm
  tumor_rad = 2mm
geometry:
  substrate1 [Rogers RT/duroid 5880 (tm)] = box(corner=(-SL/2, -SW/2, 0mm), size=(SL, SW, SH))
  Ground1 = rectangle(corner=(-SL/2, -SW/2, 0mm), x_size=SL, y_size=SW)
  coordinate_system Patch_center_CS = origin=(0mm, 0mm, SH) x=(1mm, 0mm, 0mm) y=(0mm, 1mm, 0mm)
  Patch1 = rectangle(corner=(-PL/2, -PW/2, 0mm), x_size=PL, y_size=PW) in Patch_center_CS
  coordinate_system Microstrip_CS = origin=(PL/2, 0mm, 0mm) x=(1mm, 0mm, 0mm) y=(0mm, 1mm, 0mm) in Patch_center_CS
  Microstrip1 = rectangle(corner=(0mm, -MW/2, 0mm), x_size=SL/2-PL/2, y_size=MW) in Microstrip_CS
  coordinate_system RelativeCS1 = origin=(0mm, MW/2, 0mm) x=(1mm, 0mm, 0mm) y=(0mm, 1mm, 0mm) in Microstrip_CS
  Inset1 = rectangle(corner=(0mm, 0mm, 0mm), x_size=-inL, y_size=inW) in RelativeCS1
  Inset1_1 = Inset1.duplicate_mirror(point=(0mm, -0.1mm, 0mm), normal=(0mm, -1mm, 0mm)) in RelativeCS1
  Patch1.subtract(Inset1, Inset1_1)
  coordinate_system Port_CS = origin=(SL/2-PL/2, 0, 0mm) x=(1mm, 0mm, 0mm) y=(0mm, 1mm, 0mm) in RelativeCS1
  Waveport = rectangle(corner=(0mm, -1.5mm, -SH), y_size=3mm, z_size=2*SH) in Port_CS
  Pec_cap [pec] = box(corner=(0mm, -1.5mm, -SH), size=(0.1mm, 3mm, 2*SH)) in Port_CS
  coordinate_system Center_System = origin=(0mm, 0mm, dist/2) x=(1mm, 0mm, 0mm) y=(0mm, 1mm, 0mm) in Patch_center_CS
  substrate1_1 [Rogers RT/duroid 5880 (tm)] = substrate1.duplicate_mirror(point=(0mm, 0mm, 0mm), normal=(0mm, 0mm, 1mm)) in Center_System
  Ground1_1 = Ground1.duplicate_mirror(point=(0mm, 0mm, 0mm), normal=(0mm, 0mm, 1mm)) in Center_System
  Patch1_1 = Patch1.duplicate_mirror(point=(0mm, 0mm, 0mm), normal=(0mm, 0mm, 1mm)) in Center_System
  Microstrip1_1 = Microstrip1.duplicate_mirror(point=(0mm, 0mm, 0mm), normal=(0mm, 0mm, 1mm)) in Center_System
  Waveport2 = Waveport.duplicate_mirror(point=(0mm, 0mm, 0mm), normal=(0mm, 0mm, 1mm)) in Center_System
  Pec_cap_1 [pec] = Pec_cap.duplicate_mirror(point=(0mm, 0mm, 0mm), normal=(0mm, 0mm, 1mm)) in Center_System
  coordinate_system Breast_base = origin=(0mm, 0mm, breast_offset) x=(1mm, 0mm, 0mm) y=(0mm, 1mm, 0mm) in Patch_center_CS
  Polyline1 = polyline((breast_rad, 0mm, 0mm) (6.123234e-16mm, -1.6081226e-15mm, 10mm) (-10mm, -1.9693823e-31mm, 1.2246468e-15mm), AngularArc from point 0 over 3 centre=(0mm, 0mm, 0mm) angle=180deg plane=ZX) in Breast_base
  Breast_skin [Breast_skin] = polyline((-breast_rad, 0mm, 0mm) (breast_rad, 0mm, 0mm)) in Breast_base
  Breast_skin.unite(Polyline1)
  Breast_skin.cover_lines()
  Polyline3 = polyline(xyz in mm: (0, -16.05, 0) (2.5810369e-15, 6.1547874e-16, 16.05) (9.8277906e-16, 16.05, 3.6730032e-16), AngularArc from point 0 over 3 centre=(0mm, 0mm, 0mm) angle=-180deg plane=YZ) in Breast_base
  Breast_skin.sweep_along_path(Polyline3)
  Polyline4 = polyline((breast_rad-0.5mm, 0mm, 0mm) (5.8170723e-16mm, -1.5277165e-15mm, 9.5mm) (-9.5mm, -1.8709131e-31mm, 1.1634145e-15mm), AngularArc from point 0 over 3 centre=(0mm, 0mm, 0mm) angle=180deg plane=ZX) in Breast_base
  Breast_fat [Breast_fat] = polyline((-(breast_rad-0.5mm), 0mm, 0mm) (breast_rad-0.5mm, 0mm, 0mm)) in Breast_base
  Breast_fat.unite(Polyline4)
  Breast_fat.cover_lines()
  Polyline6 = polyline(xyz in mm: (0, -9.9, 0) (1.5920414e-15, 3.7964109e-16, 9.9) (6.0620017e-16, 9.9, 2.2655907e-16), AngularArc from point 0 over 3 centre=(0mm, 0mm, 0mm) angle=-180deg plane=YZ) in Breast_base
  Breast_fat.sweep_along_path(Polyline6)
  Polyline7 = polyline((breast_rad-1mm, 0mm, 0mm) (5.5109106e-16mm, -1.4473104e-15mm, 9mm) (-9mm, -1.772444e-31mm, 1.1021821e-15mm), AngularArc from point 0 over 3 centre=(0mm, 0mm, 0mm) angle=180deg plane=ZX) in Breast_base
  Breast_fibro [Breast_fibro] = polyline((-(breast_rad-1mm), 0mm, 0mm) (breast_rad-1mm, 0mm, 0mm)) in Breast_base
  Breast_fibro.unite(Polyline7)
  Breast_fibro.cover_lines()
  Polyline9 = polyline(xyz in mm: (0, -9.8, 0) (1.5759602e-15, 3.7580633e-16, 9.8) (6.0007693e-16, 9.8, 2.242706e-16), AngularArc from point 0 over 3 centre=(0mm, 0mm, 0mm) angle=-180deg plane=YZ) in Breast_base
  Breast_fibro.sweep_along_path(Polyline9)
  Breast_fat_1 = Breast_fat.copy()
  Breast_skin.subtract(Breast_fat_1)
  Breast_fibro_1 = Breast_fibro.copy()
  Breast_fat.subtract(Breast_fibro_1)
  coordinate_system RelativeCS2 = origin=(0mm, 0mm, areola_dist) x=(1mm, 0mm, 0mm) y=(0mm, 1mm, 0mm) in Breast_base
  Polyline10 = polyline((areola_rad, 0mm, 0mm) (6.123234e-17mm, -1.6081226e-16mm, 1mm) (-1mm, -1.9693823e-32mm, 1.2246468e-16mm), AngularArc from point 0 over 3 centre=(0mm, 0mm, 0mm) angle=180deg plane=ZX) in RelativeCS2
  Areola = polyline((-areola_rad, 0mm, 0mm) (areola_rad, 0mm, 0mm)) in RelativeCS2
  Areola.unite(Polyline10)
  Polyline12 = polyline(xyz in mm: (0, -1.72, 0) (2.765971e-16, 6.5957846e-17, 1.72) (1.0531962e-16, 1.72, 3.9361778e-17), AngularArc from point 0 over 3 centre=(0mm, 0mm, 0mm) angle=-180deg plane=YZ) in RelativeCS2
  Areola.cover_lines()
  Areola.sweep_along_path(Polyline12)
  Breast_skin.unite(Areola)
  coordinate_system Tumo_location_CS = origin=(Tx, Ty, Tz) x=(1mm, 0mm, 0mm) y=(0mm, 1mm, 0mm)
  Tumor [Tumor] = sphere(centre=(0mm, 0mm, 0mm), radius=tumor_rad) in Tumo_location_CS
  Box1 [vacuum] = box(corner=(-12mm, -12mm, -8mm), size=(24mm, 24mm, 16mm)) in Center_System
boundaries and excitations:
  PerfE1: Perfect E Objects=[Ground1, Microstrip1, Patch1]
  PerfE2: Perfect E Objects=[Patch1_1, Ground1_1, Microstrip1_1]
  Rad1: Radiation Objects=Box1
  1: Wave Port Objects=Waveport NumModes=1 Modes{Mode1{IntLine{Waveport.edge(1 of 4) at 0.467 along -> Microstrip1.vertex(3 of 4)} CharImp=Zpi RenormImp=50ohm}}
  2: Wave Port Objects=Waveport2 NumModes=1 Modes{Mode1{IntLine{middle of Waveport2.edge(1 of 4) -> Microstrip1_1.vertex(4 of 4)} CharImp=Zpi RenormImp=50ohm}}
setups:
  Setup1: HfssDriven Frequency=33GHz MaxDeltaS=0.02 MaximumPasses=10 MinimumPasses=1 MinimumConvergedPasses=1 PercentRefinement=30 BasisOrder=1 PortAccuracy=2
    sweep Sweep: 32GHz to 34GHz, 20 points; Type=Discrete SaveFields
source amplitudes:
  1:1: 1W 0deg
  2:1: 0W 0deg
optimetrics:
  ParametricSetup1: Parametric Sim._Setups=[Setup1]
    sweep tumor_rad: LIN 1mm 3mm 0.5mm (synchronised group 1)
    sweep Tx: LIN 1mm 5mm 1mm (synchronised group 1)
reports:
  S Parameter Plot 1: dB(S(2,1)) vs Freq on Setup1 : Sweep [Tx=all tumor_rad=all]
