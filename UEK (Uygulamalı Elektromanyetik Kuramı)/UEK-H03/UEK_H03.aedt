# Ansys Electronics Desktop project, version 2018.0
materials:
  vacuum: permittivity=1
  Magnet_N: CoordinateSystemType=Cylindrical permittivity=1 permeability=1.0997785 conductivity=625000 magnetic_coercivity{Magnitude=-890000A_per_meter DirComp1=1 DirComp2=0 DirComp3=0} lande_g_factor=2
  Magnet_S: CoordinateSystemType=Cylindrical permittivity=1 permeability=1.0997785 conductivity=625000 magnetic_coercivity{Magnitude=-890000A_per_meter DirComp1=-1 DirComp2=0 DirComp3=0} lande_g_factor=2
  Magnetic_Eq: CoordinateSystemType=Cylindrical permittivity=1 permeability=1.0997785 conductivity=625000 magnetic_coercivity{Magnitude=-890000A_per_meter DirComp1=sin(2*(phi-0.785*(Z/40mm))) DirComp2=0 DirComp3=0} lande_g_factor=2

design Maxwell3DDesign1 (Maxwell 3D, Magnetostatic, model units mm)
geometry:
  Region [vacuum] = box(corner=(-200mm, -200mm, -200mm), size=(400mm, 400mm, 400mm))
  North1 [Magnet_N] = circle(normal=Z, centre=(0mm, 0mm, 0mm), radius=40mm)
  hole = circle(normal=Z, centre=(0mm, 0mm, 0mm), radius=30mm)
  North1.subtract(hole)
  South1 [Magnet_S] = North1.split(plane=YZ, keep=Both)
  North2 [Magnet_N] = South1.split(plane=ZX, keep=Both)
  South2 [Magnet_S] = North1.split(plane=ZX, keep=Both)
  path = polyline((0mm, 0mm, -20mm) (0mm, 0mm, 20mm))
  path_1 = path.copy()
  path_2 = path.copy()
  path_3 = path.copy()
  South2.sweep_along_path(path_3, twist=45deg)
  South1.sweep_along_path(path_2, twist=45deg)
  North2.sweep_along_path(path_1, twist=45deg)
  North1.sweep_along_path(path, twist=45deg)
  CircleA [non-model] = circle(normal=Z, centre=(0mm, 0mm, -10mm), radius=40mm, uncovered)
  CircleB, CircleC [non-model] = CircleA.duplicate_along_line(step=(0mm, 0mm, 10mm), total=3)
mesh:
  Inside: LengthBased RefineInside Objects=[North1, North2, South1, South2] MaxLength=6.5mm
  Surface: SurfApproxBased Objects=[South2, South1, North2, North1] CurvedSurfaceApproxChoice=ManualSettings NormalDev=3deg
  initial mesh: GlobalCurvilinear{Apply}
setups:
  Setup1: Magnetostatic MaximumPasses=10 MinimumPasses=2 MinimumConvergedPasses=1 PercentRefinement=30 PercentError=0.1 NonLinearResidual=0.001
field calculator expressions:
  Brad = Fundamental_Quantity(22) | Smooth | ScalarX | Scalar_Function(FuncValue='PHI') | UMathFunc | * | Fundamental_Quantity(22) | Smooth | ScalarY | Scalar_Function(FuncValue='PHI') | UMathFunc | * | +
field plots:
  B_Vector1: B over North1, North2, South1, South2 on Setup1 : LastAdaptive
reports:
  Calculator Expressions Plot 1: Brad, Brad, Brad vs Distance on Setup1 : LastAdaptive

design Sin_Material (Maxwell 3D, Magnetostatic, model units mm)
geometry:
  Region [vacuum] = box(corner=(-200mm, -200mm, -200mm), size=(400mm, 400mm, 400mm))
  Ring_Magnet [Magnetic_Eq] = circle(normal=Z, centre=(0mm, 0mm, 0mm), radius=40mm)
  hole = circle(normal=Z, centre=(0mm, 0mm, 0mm), radius=30mm)
  Ring_Magnet.subtract(hole)
  path = polyline((0mm, 0mm, -20mm) (0mm, 0mm, 20mm))
  path_1 = path.copy()
  path_1.delete()
  path_2 = path.copy()
  path_2.delete()
  path_3 = path.copy()
  path_3.delete()
  Ring_Magnet.sweep_along_path(path)
  CircleA [non-model] = circle(normal=Z, centre=(0mm, 0mm, -10mm), radius=40mm, uncovered)
  CircleB, CircleC [non-model] = CircleA.duplicate_along_line(step=(0mm, 0mm, 10mm), total=3)
mesh:
  Inside: LengthBased RefineInside Objects=Ring_Magnet MaxLength=6.5mm
  Surface: SurfApproxBased Objects=Ring_Magnet CurvedSurfaceApproxChoice=ManualSettings NormalDev=3deg
  initial mesh: GlobalCurvilinear{Apply}
setups:
  Setup1: Magnetostatic MaximumPasses=10 MinimumPasses=2 MinimumConvergedPasses=1 PercentRefinement=30 PercentError=0.1 NonLinearResidual=0.001
field calculator expressions:
  Brad = Fundamental_Quantity(22) | Smooth | ScalarX | Scalar_Function(FuncValue='PHI') | UMathFunc | * | Fundamental_Quantity(22) | Smooth | ScalarY | Scalar_Function(FuncValue='PHI') | UMathFunc | * | +
field plots:
  B_Vector1: B over Ring_Magnet on Setup1 : LastAdaptive
reports:
  Calculator Expressions Plot 1: Brad, Brad, Brad vs Distance on Setup1 : LastAdaptive
