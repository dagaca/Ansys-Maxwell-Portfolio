# Ansys Electronics Desktop project, version 2018.0
materials:
  vacuum: permittivity=1
  FRP_core: permittivity=7.2 conductivity=10^-12
  steel_1008: permeability{BType=normal HUnit=A_per_meter BUnit=tesla curve (0, 0) (159.2, 0.2402) (318.3, 0.8654) (477.5, 1.1106) (636.6, 1.2458) (795.8, 1.331) (1591.5, 1.5) (3183.1, 1.6) (4774.6, 1.683) (6366.2, 1.741) (7957.7, 1.78) (15915.5, 1.905) (31831, 2.025) (47746.5, 2.085) (63662, 2.13) (79577.5, 2.165) (159155, 2.28) (318310, 2.485) (397887, 2.5851)} conductivity=2000000
  silicone_rubber: permittivity=4.3 conductivity=10^-12
  air: permittivity=1.0006 permeability=1.0000004

design Maxwell2DDesign1 (Maxwell 2D, Electrostatic, about Z geometry, model units mm)
geometry:
  composite_insulator_model2b_Unnamed_1, composite_insulator_model2b_Unnamed_2 = imported_body(C:\Users\dagac\OneDrive\MasaÃ¼stÃ¼\UEK_H08\model2b\composite_insulator_model2b.iges)
  silicone_rubber2_1 [silicone_rubber] = imported_body(C:\Users\dagac\OneDrive\MasaÃ¼stÃ¼\UEK_H08\model2b\composite_insulator_model2b.iges)
  composite_insulator_model2b_Unnamed_4 = imported_body(C:\Users\dagac\OneDrive\MasaÃ¼stÃ¼\UEK_H08\model2b\composite_insulator_model2b.iges)
  silicone_rubber1_2 [silicone_rubber] = imported_body(C:\Users\dagac\OneDrive\MasaÃ¼stÃ¼\UEK_H08\model2b\composite_insulator_model2b.iges)
  composite_insulator_model2b_Unnamed_6 = imported_body(C:\Users\dagac\OneDrive\MasaÃ¼stÃ¼\UEK_H08\model2b\composite_insulator_model2b.iges)
  steel2 [steel_1008] = imported_body(C:\Users\dagac\OneDrive\MasaÃ¼stÃ¼\UEK_H08\model2b\composite_insulator_model2b.iges)
  composite_insulator_model2b_Unnamed_8..composite_insulator_model2b_Unnamed_18 = imported_body(C:\Users\dagac\OneDrive\MasaÃ¼stÃ¼\UEK_H08\model2b\composite_insulator_model2b.iges)
  steel1 [steel_1008] = imported_body(C:\Users\dagac\OneDrive\MasaÃ¼stÃ¼\UEK_H08\model2b\composite_insulator_model2b.iges)
  composite_insulator_model2b_Unnamed_20 = imported_body(C:\Users\dagac\OneDrive\MasaÃ¼stÃ¼\UEK_H08\model2b\composite_insulator_model2b.iges)
  steel1.unite(composite_insulator_model2b_Unnamed_20, composite_insulator_model2b_Unnamed_14, composite_insulator_model2b_Unnamed_16, composite_insulator_model2b_Unnamed_17, composite_insulator_model2b_Unnamed_15, composite_insulator_model2b_Unnamed_18)
  steel1.cover_lines()
  steel2.unite(composite_insulator_model2b_Unnamed_9, composite_insulator_model2b_Unnamed_8, composite_insulator_model2b_Unnamed_11, composite_insulator_model2b_Unnamed_10, composite_insulator_model2b_Unnamed_13, composite_insulator_model2b_Unnamed_12)
  steel2.cover_lines()
  composite_insulator_model2b_Unnamed_7_ObjectFromEdge1..composite_insulator_model2b_Unnamed_7_ObjectFromEdge4 = object_from(?.edge(#52, #57, #47, #42))
  silicone_rubber2_2, silicone_rubber1_1 [silicone_rubber], composite_insulator_model2b_Unnamed_19_ObjectFromEdge1, composite_insulator_model2b_Unnamed_19_ObjectFromEdge3 = object_from(?.edge(#87, #82, #77, #92))
  silicone_rubber2_1.unite(composite_insulator_model2b_Unnamed_4, composite_insulator_model2b_Unnamed_7_ObjectFromEdge1, composite_insulator_model2b_Unnamed_19_ObjectFromEdge1)
  silicone_rubber2_1.cover_lines()
  silicone_rubber1_1.unite(composite_insulator_model2b_Unnamed_1, composite_insulator_model2b_Unnamed_2, composite_insulator_model2b_Unnamed_7_ObjectFromEdge2)
  silicone_rubber1_1.cover_lines()
  composite_insulator_model2b_Unnamed_19_ObjectFromEdge4_ObjectFromEdge1 = object_from(?.edge(#7))
  composite_insulator_model2b_Unnamed_3_ObjectFromEdge1 = object_from(?.edge(#17))
  silicone_rubber1_2.unite(composite_insulator_model2b_Unnamed_19_ObjectFromEdge4_ObjectFromEdge1, composite_insulator_model2b_Unnamed_7_ObjectFromEdge4, composite_insulator_model2b_Unnamed_19_ObjectFromEdge3)
  silicone_rubber1_2.cover_lines()
  silicone_rubber2_2.unite(composite_insulator_model2b_Unnamed_6, composite_insulator_model2b_Unnamed_3_ObjectFromEdge1, composite_insulator_model2b_Unnamed_7_ObjectFromEdge3)
  silicone_rubber2_2.cover_lines()
  core [FRP_core] = object_from(?.edge(#72))
  composite_insulator_model2b_Unnamed_19_ObjectFromEdge2_ObjectFromEdge1 = object_from(?.edge(#32))
  composite_insulator_model2b_Unnamed_5_ObjectFromEdge1 = object_from(?.edge(#27))
  composite_insulator_model2b_Unnamed_7_ObjectFromEdge5 = object_from(?.edge(#37))
  core.unite(composite_insulator_model2b_Unnamed_19_ObjectFromEdge2_ObjectFromEdge1, composite_insulator_model2b_Unnamed_5_ObjectFromEdge1, composite_insulator_model2b_Unnamed_7_ObjectFromEdge5)
  core.cover_lines()
  Region [air] = region(+X=60 percentage offset, -X=0mm absolute position, +Y=0 percentage offset, -Y=0 percentage offset, +Z=60 percentage offset, -Z=60 percentage offset)
  group composite_insulator_model2b = silicone_rubber2_1, silicone_rubber1_2, steel2, steel1, silicone_rubber2_2, silicone_rubber1_1, core
mesh:
  initial mesh: MeshMethod=AnsoftTAU
