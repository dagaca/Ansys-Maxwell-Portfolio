# Ansys Electronics Desktop project, version 2018.0
materials:
  vacuum: permittivity=1
  FRP_core: permittivity=7.2 conductivity=10^-12
  steel_1008: permeability{BType=normal HUnit=A_per_meter BUnit=tesla curve (0, 0) (159.2, 0.2402) (318.3, 0.8654) (477.5, 1.1106) (636.6, 1.2458) (795.8, 1.331) (1591.5, 1.5) (3183.1, 1.6) (4774.6, 1.683) (6366.2, 1.741) (7957.7, 1.78) (15915.5, 1.905) (31831, 2.025) (47746.5, 2.085) (63662, 2.13) (79577.5, 2.165) (159155, 2.28) (318310, 2.485) (397887, 2.5851)} conductivity=2000000
  silicone rubber: permittivity=4.3 conductivity=10^-12
  air: permittivity=1.0006 permeability=1.0000004

design Maxwell2DDesign1 (Maxwell 2D, Electrostatic, about Z geometry, model units mm)
geometry:
  composite_insulator_model1b_Unnamed_1..composite_insulator_model1b_Unnamed_12 = imported_body(C:\Users\dagac\OneDrive\MasaÃ¼stÃ¼\UEK_H08\model1b\composite_insulator_model1b.iges)
  steel2 [steel_1008] = imported_body(C:\Users\dagac\OneDrive\MasaÃ¼stÃ¼\UEK_H08\model1b\composite_insulator_model1b.iges)
  composite_insulator_model1b_Unnamed_14..composite_insulator_model1b_Unnamed_18 = imported_body(C:\Users\dagac\OneDrive\MasaÃ¼stÃ¼\UEK_H08\model1b\composite_insulator_model1b.iges)
  steel1 [steel_1008] = imported_body(C:\Users\dagac\OneDrive\MasaÃ¼stÃ¼\UEK_H08\model1b\composite_insulator_model1b.iges)
  composite_insulator_model1b_Unnamed_20 = imported_body(C:\Users\dagac\OneDrive\MasaÃ¼stÃ¼\UEK_H08\model1b\composite_insulator_model1b.iges)
  steel1.unite(composite_insulator_model1b_Unnamed_20, composite_insulator_model1b_Unnamed_14, composite_insulator_model1b_Unnamed_18, composite_insulator_model1b_Unnamed_17, composite_insulator_model1b_Unnamed_15, composite_insulator_model1b_Unnamed_16)
  steel1.cover_lines()
  steel2.unite(composite_insulator_model1b_Unnamed_11, composite_insulator_model1b_Unnamed_10, composite_insulator_model1b_Unnamed_7, composite_insulator_model1b_Unnamed_8, composite_insulator_model1b_Unnamed_9, composite_insulator_model1b_Unnamed_12)
  steel2.cover_lines()
  composite_insulator_model1b_Unnamed_19_ObjectFromEdge1 = object_from(?.edge(#92))
  silicone_rubber2_1 [silicone rubber] = object_from(?.edge(#57))
  silicone_rubber2_1.unite(composite_insulator_model1b_Unnamed_19_ObjectFromEdge1, composite_insulator_model1b_Unnamed_5, composite_insulator_model1b_Unnamed_4)
  silicone_rubber2_1.cover_lines()
  composite_insulator_model1b_Unnamed_19_ObjectFromEdge2 = object_from(?.edge(#82))
  silicone_rubber1_1 [silicone rubber] = object_from(?.edge(#47))
  silicone_rubber1_1.unite(composite_insulator_model1b_Unnamed_19_ObjectFromEdge2, composite_insulator_model1b_Unnamed_2, composite_insulator_model1b_Unnamed_1)
  silicone_rubber1_1.cover_lines()
  composite_insulator_model1b_Unnamed_13_ObjectFromEdge3 = object_from(?.edge(#52))
  composite_insulator_model1b_Unnamed_19_ObjectFromEdge3 = object_from(?.edge(#87))
  silicone_rubber2_2 [silicone rubber] = object_from(?.edge(#27))
  silicone_rubber2_2.unite(composite_insulator_model1b_Unnamed_13_ObjectFromEdge3, composite_insulator_model1b_Unnamed_19_ObjectFromEdge3, composite_insulator_model1b_Unnamed_6)
  silicone_rubber2_2.cover_lines()
  composite_insulator_model1b_Unnamed_19_ObjectFromEdge4 = object_from(?.edge(#77))
  silicone_rubber1_2 [silicone rubber] = object_from(?.edge(#12))
  composite_insulator_model1b_Unnamed_13_ObjectFromEdge4 = object_from(?.edge(#42))
  silicone_rubber1_2.unite(composite_insulator_model1b_Unnamed_13_ObjectFromEdge4, composite_insulator_model1b_Unnamed_19_ObjectFromEdge4, composite_insulator_model1b_Unnamed_3)
  silicone_rubber1_2.cover_lines()
  core [FRP_core] = object_from(?.edge(#17))
  composite_insulator_model1b_Unnamed_13_ObjectFromEdge1_ObjectFromEdge1_ObjectFromEdge1 = object_from(?.edge(#32))
  composite_insulator_model1b_Unnamed_13_ObjectFromEdge5 = object_from(?.edge(#37))
  composite_insulator_model1b_Unnamed_19_ObjectFromEdge5 = object_from(?.edge(#72))
  core.unite(composite_insulator_model1b_Unnamed_13_ObjectFromEdge1_ObjectFromEdge1_ObjectFromEdge1, composite_insulator_model1b_Unnamed_13_ObjectFromEdge5, composite_insulator_model1b_Unnamed_19_ObjectFromEdge5)
  core.cover_lines()
  Region [air] = region(+X=60 percentage offset, -X=0mm absolute position, +Y=0 percentage offset, -Y=0 percentage offset, +Z=60 percentage offset, -Z=60 percentage offset)
  group composite_insulator_model1b = steel2, steel1, silicone_rubber2_1, silicone_rubber1_1, silicone_rubber2_2, silicone_rubber1_2, core
mesh:
  initial mesh: MeshMethod=AnsoftTAU
