# Ansys Electronics Desktop project, version 2018.0
materials:
  vacuum: permittivity=1
  steel_1008: permeability{BType=normal HUnit=A_per_meter BUnit=tesla curve (0, 0) (159.2, 0.2402) (318.3, 0.8654) (477.5, 1.1106) (636.6, 1.2458) (795.8, 1.331) (1591.5, 1.5) (3183.1, 1.6) (4774.6, 1.683) (6366.2, 1.741) (7957.7, 1.78) (15915.5, 1.905) (31831, 2.025) (47746.5, 2.085) (63662, 2.13) (79577.5, 2.165) (159155, 2.28) (318310, 2.485) (397887, 2.5851)} conductivity=2000000
  FRP_core: permittivity=7.2 conductivity=10^-12
  silicone_rubber: permittivity=4.3 conductivity=10^-12
  air: permittivity=1.0006 permeability=1.0000004

design Maxwell2DDesign1 (Maxwell 2D, Electrostatic, about Z geometry, model units mm)
geometry:
  air [air] = imported_body(C:\Users\dagac\OneDrive\MasaÃ¼stÃ¼\UEK_H08\model3a\composite_insulator_model3a.iges)
  composite_insulator_model3a_Unnamed_2..composite_insulator_model3a_Unnamed_15 = imported_body(C:\Users\dagac\OneDrive\MasaÃ¼stÃ¼\UEK_H08\model3a\composite_insulator_model3a.iges)
  silicone_rubber [silicone_rubber] = imported_body(C:\Users\dagac\OneDrive\MasaÃ¼stÃ¼\UEK_H08\model3a\composite_insulator_model3a.iges)
  composite_insulator_model3a_Unnamed_17, composite_insulator_model3a_Unnamed_18 = imported_body(C:\Users\dagac\OneDrive\MasaÃ¼stÃ¼\UEK_H08\model3a\composite_insulator_model3a.iges)
  steel1 [steel_1008] = imported_body(C:\Users\dagac\OneDrive\MasaÃ¼stÃ¼\UEK_H08\model3a\composite_insulator_model3a.iges)
  composite_insulator_model3a_Unnamed_20 = imported_body(C:\Users\dagac\OneDrive\MasaÃ¼stÃ¼\UEK_H08\model3a\composite_insulator_model3a.iges)
  steel1.unite(composite_insulator_model3a_Unnamed_20, composite_insulator_model3a_Unnamed_18, composite_insulator_model3a_Unnamed_17, composite_insulator_model3a_Unnamed_7, composite_insulator_model3a_Unnamed_13, composite_insulator_model3a_Unnamed_12, composite_insulator_model3a_Unnamed_11)
  steel1.cover_lines()
  air.unite(composite_insulator_model3a_Unnamed_2)
  air.cover_lines()
  silicone_rubber2 [silicone_rubber], composite_insulator_model3a_Unnamed_19_ObjectFromEdge2 = object_from(?.edge(#35, #65))
  composite_insulator_model3a_Unnamed_9_ObjectFromEdge1 = object_from(?.edge(#45))
  composite_insulator_model3a_Unnamed_9.delete()
  composite_insulator_model3a_Unnamed_15_ObjectFromEdge1 = object_from(?.edge(#75))
  composite_insulator_model3a_Unnamed_15.delete()
  silicone_rubber2.unite(composite_insulator_model3a_Unnamed_10, composite_insulator_model3a_Unnamed_8, composite_insulator_model3a_Unnamed_9_ObjectFromEdge1)
  silicone_rubber2.cover_lines()
  silicone_rubber.unite(composite_insulator_model3a_Unnamed_14, composite_insulator_model3a_Unnamed_19_ObjectFromEdge2, composite_insulator_model3a_Unnamed_15_ObjectFromEdge1)
  silicone_rubber.cover_lines()
  steel2 [steel_1008] = object_from(silicone_rubber2.edge(1 of 1))
  composite_insulator_model3a_Unnamed_16_ObjectFromEdge1 = object_from(silicone_rubber.edge(1 of 1))
  steel2.unite(composite_insulator_model3a_Unnamed_5, composite_insulator_model3a_Unnamed_4, composite_insulator_model3a_Unnamed_3, composite_insulator_model3a_Unnamed_6, composite_insulator_model3a_Unnamed_16_ObjectFromEdge1)
  steel2.cover_lines()
  composite_insulator_model3a_Unnamed_19_ObjectFromEdge1_ObjectFromEdge2 = object_from(?.edge(#40))
  composite_insulator_model3a_Unnamed_16_ObjectFromEdge2 = object_from(?.edge(#70))
  composite_insulator_model3a_Unnamed_19_ObjectFromEdge1_ObjectFromEdge1_ObjectFromEdge1, composite_insulator_model3a_Unnamed_19_ObjectFromEdge1_ObjectFromEdge1_ObjectFromEdge2 = object_from(?.edge(#30, #25))
  core [FRP_core], composite_insulator_model3a_Unnamed_19_ObjectFromEdge4 = object_from(?.edge(#60, #55))
  core.unite(composite_insulator_model3a_Unnamed_19_ObjectFromEdge4, composite_insulator_model3a_Unnamed_19_ObjectFromEdge1_ObjectFromEdge2, composite_insulator_model3a_Unnamed_16_ObjectFromEdge2, composite_insulator_model3a_Unnamed_19_ObjectFromEdge1_ObjectFromEdge1_ObjectFromEdge2, composite_insulator_model3a_Unnamed_19_ObjectFromEdge1_ObjectFromEdge1_ObjectFromEdge1)
  core.cover_lines()
  Region [air] = region(+X=60 percentage offset, -X=0mm absolute position, +Y=0 percentage offset, -Y=0 percentage offset, +Z=60 percentage offset, -Z=60 percentage offset)
  group composite_insulator_model3a = air, silicone_rubber, steel1, silicone_rubber2, steel2, core
mesh:
  initial mesh: MeshMethod=AnsoftTAU
