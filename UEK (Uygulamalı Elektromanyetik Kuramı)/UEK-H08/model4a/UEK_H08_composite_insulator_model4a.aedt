# Ansys Electronics Desktop project, version 2018.0
materials:
  vacuum: permittivity=1
  FRP_core: permittivity=7.2 conductivity=10^-12
  silicone_rubber: permittivity=4.3 conductivity=10^-12
  steel_1008: permeability{BType=normal HUnit=A_per_meter BUnit=tesla curve (0, 0) (159.2, 0.2402) (318.3, 0.8654) (477.5, 1.1106) (636.6, 1.2458) (795.8, 1.331) (1591.5, 1.5) (3183.1, 1.6) (4774.6, 1.683) (6366.2, 1.741) (7957.7, 1.78) (15915.5, 1.905) (31831, 2.025) (47746.5, 2.085) (63662, 2.13) (79577.5, 2.165) (159155, 2.28) (318310, 2.485) (397887, 2.5851)} conductivity=2000000
  air: permittivity=1.0006 permeability=1.0000004

design Maxwell2DDesign1 (Maxwell 2D, Electrostatic, about Z geometry, model units mm)
geometry:
  air [air] = imported_body(C:\Users\dagac\OneDrive\MasaÃ¼stÃ¼\UEK_H08\model4a\composite_insulator_model4a.iges)
  composite_insulator_model4a_Unnamed_2..composite_insulator_model4a_Unnamed_5 = imported_body(C:\Users\dagac\OneDrive\MasaÃ¼stÃ¼\UEK_H08\model4a\composite_insulator_model4a.iges)
  silicone_rubber2, silicone_rubber [silicone_rubber] = imported_body(C:\Users\dagac\OneDrive\MasaÃ¼stÃ¼\UEK_H08\model4a\composite_insulator_model4a.iges)
  composite_insulator_model4a_Unnamed_8..composite_insulator_model4a_Unnamed_16 = imported_body(C:\Users\dagac\OneDrive\MasaÃ¼stÃ¼\UEK_H08\model4a\composite_insulator_model4a.iges)
  steel1 [steel_1008] = imported_body(C:\Users\dagac\OneDrive\MasaÃ¼stÃ¼\UEK_H08\model4a\composite_insulator_model4a.iges)
  composite_insulator_model4a_Unnamed_18 = imported_body(C:\Users\dagac\OneDrive\MasaÃ¼stÃ¼\UEK_H08\model4a\composite_insulator_model4a.iges)
  silicone_rubber.unite(composite_insulator_model4a_Unnamed_13, composite_insulator_model4a_Unnamed_5, composite_insulator_model4a_Unnamed_9)
  silicone_rubber.cover_lines()
  silicone_rubber2.unite(composite_insulator_model4a_Unnamed_14, composite_insulator_model4a_Unnamed_11, composite_insulator_model4a_Unnamed_10)
  silicone_rubber2.cover_lines()
  composite_insulator_model4a_Unnamed_7_ObjectFromEdge1, composite_insulator_model4a_Unnamed_7_ObjectFromEdge2 = object_from(?.edge(#410, #390))
  steel2 [steel_1008], composite_insulator_model4a_Unnamed_6_ObjectFromEdge1 = object_from(?.edge(#415, #395))
  steel1.unite(composite_insulator_model4a_Unnamed_18, composite_insulator_model4a_Unnamed_12, composite_insulator_model4a_Unnamed_16, composite_insulator_model4a_Unnamed_15, composite_insulator_model4a_Unnamed_7_ObjectFromEdge1, composite_insulator_model4a_Unnamed_6_ObjectFromEdge1)
  steel1.cover_lines()
  air.unite(composite_insulator_model4a_Unnamed_2)
  air.cover_lines()
  steel2.unite(composite_insulator_model4a_Unnamed_8, composite_insulator_model4a_Unnamed_7_ObjectFromEdge2, composite_insulator_model4a_Unnamed_3, composite_insulator_model4a_Unnamed_4)
  steel2.cover_lines()
  core [FRP_core] = object_from(?.edge(#370))
  composite_insulator_model4a_Unnamed_6_ObjectFromEdge3 = object_from(?.edge(#375))
  composite_insulator_model4a_Unnamed_6_ObjectFromEdge2_ObjectFromEdge1 = object_from(?.edge(#385))
  composite_insulator_model4a_Unnamed_17_ObjectFromEdge1 = object_from(?.edge(#405))
  core.unite(composite_insulator_model4a_Unnamed_6_ObjectFromEdge3, composite_insulator_model4a_Unnamed_6_ObjectFromEdge2_ObjectFromEdge1, composite_insulator_model4a_Unnamed_17_ObjectFromEdge1)
  core.cover_lines()
  Region [air] = region(+X=60 percentage offset, -X=0mm absolute position, +Y=0 percentage offset, -Y=0 percentage offset, +Z=60 percentage offset, -Z=60 percentage offset)
  group composite_insulator_model4a = air, silicone_rubber2, silicone_rubber, steel1, steel2, core
mesh:
  initial mesh: MeshMethod=AnsoftTAU
