# Ansys Electronics Desktop project, version 2018.0
materials:
  vacuum: permittivity=1
  steel_1008: permeability{BType=normal HUnit=A_per_meter BUnit=tesla curve (0, 0) (159.2, 0.2402) (318.3, 0.8654) (477.5, 1.1106) (636.6, 1.2458) (795.8, 1.331) (1591.5, 1.5) (3183.1, 1.6) (4774.6, 1.683) (6366.2, 1.741) (7957.7, 1.78) (15915.5, 1.905) (31831, 2.025) (47746.5, 2.085) (63662, 2.13) (79577.5, 2.165) (159155, 2.28) (318310, 2.485) (397887, 2.5851)} conductivity=2000000
  silicone_rubber: permittivity=4.3 conductivity=10^-12
  FRP_core: permittivity=7.2 conductivity=10^-12
  air: permittivity=1.0006 permeability=1.0000004

design Maxwell2DDesign1 (Maxwell 2D, Electrostatic, about Z geometry, model units mm)
geometry:
  composite_insulator_model1a_Unnamed_1..composite_insulator_model1a_Unnamed_5 = imported_body(C:\Users\dagac\OneDrive\MasaÃ¼stÃ¼\UEK_H08\composite_insulator_model1a.iges)
  core [FRP_core] = imported_body(C:\Users\dagac\OneDrive\MasaÃ¼stÃ¼\UEK_H08\composite_insulator_model1a.iges)
  composite_insulator_model1a_Unnamed_7..composite_insulator_model1a_Unnamed_11 = imported_body(C:\Users\dagac\OneDrive\MasaÃ¼stÃ¼\UEK_H08\composite_insulator_model1a.iges)
  steel1 [steel_1008] = imported_body(C:\Users\dagac\OneDrive\MasaÃ¼stÃ¼\UEK_H08\composite_insulator_model1a.iges)
  composite_insulator_model1a_Unnamed_13..composite_insulator_model1a_Unnamed_18 = imported_body(C:\Users\dagac\OneDrive\MasaÃ¼stÃ¼\UEK_H08\composite_insulator_model1a.iges)
  steel2 [steel_1008] = imported_body(C:\Users\dagac\OneDrive\MasaÃ¼stÃ¼\UEK_H08\composite_insulator_model1a.iges)
  composite_insulator_model1a_Unnamed_20, composite_insulator_model1a_Unnamed_21, composite_insulator_model1a_Unnamed_22 = imported_body(C:\Users\dagac\OneDrive\MasaÃ¼stÃ¼\UEK_H08\composite_insulator_model1a.iges)
  steel1.unite(composite_insulator_model1a_Unnamed_22, composite_insulator_model1a_Unnamed_21, composite_insulator_model1a_Unnamed_20, composite_insulator_model1a_Unnamed_14, composite_insulator_model1a_Unnamed_13, composite_insulator_model1a_Unnamed_15, composite_insulator_model1a_Unnamed_16)
  steel1.cover_lines()
  steel2.unite(composite_insulator_model1a_Unnamed_7, composite_insulator_model1a_Unnamed_18, composite_insulator_model1a_Unnamed_17, composite_insulator_model1a_Unnamed_9, composite_insulator_model1a_Unnamed_8, composite_insulator_model1a_Unnamed_10, composite_insulator_model1a_Unnamed_11)
  steel2.cover_lines()
  silicon_rubber1_1, silicon_rubber2_1 [silicone_rubber] = object_from(?.edge(#193, #183))
  composite_insulator_model1a_Unnamed_19_ObjectFromEdge1, composite_insulator_model1a_Unnamed_19_ObjectFromEdge2 = object_from(?.edge(#158, #168))
  silicon_rubber2_1.unite(composite_insulator_model1a_Unnamed_4, composite_insulator_model1a_Unnamed_3, composite_insulator_model1a_Unnamed_19_ObjectFromEdge1)
  silicon_rubber2_1.cover_lines()
  silicon_rubber1_1.unite(composite_insulator_model1a_Unnamed_19_ObjectFromEdge2, composite_insulator_model1a_Unnamed_2, composite_insulator_model1a_Unnamed_1)
  silicon_rubber1_1.cover_lines()
  composite_insulator_model1a_Unnamed_12_ObjectFromEdge3 = object_from(?.edge(#173))
  composite_insulator_model1a_Unnamed_19_ObjectFromEdge3 = object_from(?.edge(#148))
  core.unite(composite_insulator_model1a_Unnamed_5, composite_insulator_model1a_Unnamed_12_ObjectFromEdge3, composite_insulator_model1a_Unnamed_19_ObjectFromEdge3)
  core.cover_lines()
  silicon_rubber2_2 [silicone_rubber] = object_from(?.edge(#128))
  silicon_rubber1_2 [silicone_rubber] = object_from(?.edge(#118))
  composite_insulator_model1a_Unnamed_12_ObjectFromEdge4 = object_from(?.edge(#178))
  composite_insulator_model1a_Unnamed_19_ObjectFromEdge4 = object_from(?.edge(#153))
  composite_insulator_model1a_Unnamed_6_ObjectFromEdge1 = object_from(?.edge(#143))
  silicon_rubber2_2.unite(composite_insulator_model1a_Unnamed_12_ObjectFromEdge4, composite_insulator_model1a_Unnamed_6_ObjectFromEdge1, composite_insulator_model1a_Unnamed_19_ObjectFromEdge4)
  silicon_rubber2_2.cover_lines()
  composite_insulator_model1a_Unnamed_12_ObjectFromEdge5 = object_from(?.edge(#188))
  composite_insulator_model1a_Unnamed_6_ObjectFromEdge2 = object_from(?.edge(#138))
  composite_insulator_model1a_Unnamed_19_ObjectFromEdge5 = object_from(?.edge(#163))
  silicon_rubber1_2.unite(composite_insulator_model1a_Unnamed_19_ObjectFromEdge5, composite_insulator_model1a_Unnamed_6_ObjectFromEdge2, composite_insulator_model1a_Unnamed_12_ObjectFromEdge5)
  silicon_rubber1_2.cover_lines()
  Region [air] = region(+X=60 percentage offset, -X=0mm absolute position, +Y=0 percentage offset, -Y=0 percentage offset, +Z=60 percentage offset, -Z=60 percentage offset)
  group composite_insulator_model1a = core, steel1, steel2, silicon_rubber1_1, silicon_rubber2_1, silicon_rubber2_2, silicon_rubber1_2
mesh:
  initial mesh: MeshMethod=AnsoftTAU
