# Ansys Electronics Desktop project, version 2018.0
materials:
  vacuum: permittivity=1
  copper: permeability=0.999991 conductivity=58000000
  perfect conductor: conductivity=1e+30

design Maxwell3DDesign1 (Maxwell 3D, Magnetostatic, model units mm)
geometry:
  Solenoid [copper] = user_primitive(SegmentedHelix/PolygonHelix.dll, PolygonSegments=8, PolygonRadius=0.5mm, StartHelixRadius=5mm, RadiusChange=0mm, Pitch=1.5mm, Turns=20, SegmentsPerTurn=0, RightHanded=1)
  Material_outside [perfect conductor] = box(corner=(-6mm, -50mm, -35mm), size=(5mm, 100mm, 100mm))
  Box2 = box(corner=(-6mm, -20mm, -5mm), size=(5mm, 40mm, 40mm))
  Material_outside.subtract(Box2)
  Cpath_up [copper] = polyline(z=30mm, xy in mm: (5, 0) (5, 15) (-15, 15), section rectangle width=0.5mm height=0.5mm)
  Cpath_down [copper] = polyline(z=0mm, xy in mm: (5, 0) (5, -10) (-15, -10), section rectangle width=0.5mm height=0.5mm)
  Region [vacuum] = region(percentage_offset=0 on all sides)
boundaries and excitations:
  Current1: Current Faces=Cpath_up.face(at (-15, 15, 30)) Current=120A IsSolid=true Point_out_of_terminal=true
  Current2: Current Faces=Cpath_down.face(at (-15, -10, 0)) Current=120A IsSolid=true Point_out_of_terminal=false
mesh:
  initial mesh: GlobalCurvilinear{Apply}
setups:
  Setup1: Magnetostatic MaximumPasses=10 MinimumPasses=2 MinimumConvergedPasses=1 PercentRefinement=30 PercentError=1 NonLinearResidual=0.001
field plots:
  B_Vector1: B on Setup1 : LastAdaptive
  Mag_B1: B over a plane on Setup1 : LastAdaptive
