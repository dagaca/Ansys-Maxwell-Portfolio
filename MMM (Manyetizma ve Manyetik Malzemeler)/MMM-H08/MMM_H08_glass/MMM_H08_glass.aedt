# Ansys Electronics Desktop project, version 2018.0
materials:
  vacuum: permittivity=1
  glass: permittivity=5.5
  steel_1008: permeability{BType=normal HUnit=A_per_meter BUnit=tesla curve (0, 0) (159.2, 0.2402) (318.3, 0.8654) (477.5, 1.1106) (636.6, 1.2458) (795.8, 1.331) (1591.5, 1.5) (3183.1, 1.6) (4774.6, 1.683) (6366.2, 1.741) (7957.7, 1.78) (15915.5, 1.905) (31831, 2.025) (47746.5, 2.085) (63662, 2.13) (79577.5, 2.165) (159155, 2.28) (318310, 2.485) (397887, 2.5851)} conductivity=2000000
  cement: permittivity=2.09 conductivity=10^-14
  air: permittivity=1.0006 permeability=1.0000004

design Maxwell2DDesign1 (Maxwell 2D, Electrostatic, about Z geometry, model units mm)
geometry:
  glass_insulator_MMM_Unnamed_1..glass_insulator_MMM_Unnamed_8 = imported_body(C:\Users\dagac\OneDrive\MasaÃ¼stÃ¼\MMM_H08\glass_insulator_MMM.iges)
  cap [steel_1008] = imported_body(C:\Users\dagac\OneDrive\MasaÃ¼stÃ¼\MMM_H08\glass_insulator_MMM.iges)
  glass_insulator_MMM_Unnamed_10..glass_insulator_MMM_Unnamed_13 = imported_body(C:\Users\dagac\OneDrive\MasaÃ¼stÃ¼\MMM_H08\glass_insulator_MMM.iges)
  pin [steel_1008] = imported_body(C:\Users\dagac\OneDrive\MasaÃ¼stÃ¼\MMM_H08\glass_insulator_MMM.iges)
  glass_insulator_MMM_Unnamed_15, glass_insulator_MMM_Unnamed_16 = imported_body(C:\Users\dagac\OneDrive\MasaÃ¼stÃ¼\MMM_H08\glass_insulator_MMM.iges)
  glass [glass] = imported_body(C:\Users\dagac\OneDrive\MasaÃ¼stÃ¼\MMM_H08\glass_insulator_MMM.iges)
  glass_insulator_MMM_Unnamed_18 = imported_body(C:\Users\dagac\OneDrive\MasaÃ¼stÃ¼\MMM_H08\glass_insulator_MMM.iges)
  cap.unite(glass_insulator_MMM_Unnamed_18, glass_insulator_MMM_Unnamed_7, glass_insulator_MMM_Unnamed_3, glass_insulator_MMM_Unnamed_4, glass_insulator_MMM_Unnamed_10)
  cap.cover_lines()
  glass.unite(glass_insulator_MMM_Unnamed_2, glass_insulator_MMM_Unnamed_15, glass_insulator_MMM_Unnamed_16)
  glass.cover_lines()
  pin.unite(glass_insulator_MMM_Unnamed_11, glass_insulator_MMM_Unnamed_12)
  pin.cover_lines()
  cement1 [cement], glass_insulator_MMM_Unnamed_9_ObjectFromEdge2 = object_from(?.edge(#402, #457))
  glass_insulator_MMM_Unnamed_17_ObjectFromEdge1 = object_from(?.edge(#452))
  cement1.unite(glass_insulator_MMM_Unnamed_9_ObjectFromEdge2, glass_insulator_MMM_Unnamed_17_ObjectFromEdge1, glass_insulator_MMM_Unnamed_5, glass_insulator_MMM_Unnamed_6)
  cement1.cover_lines()
  cement2 [cement] = object_from(?.edge(#437))
  glass_insulator_MMM_Unnamed_17_ObjectFromEdge2 = object_from(?.edge(#442))
  cement2.unite(glass_insulator_MMM_Unnamed_17_ObjectFromEdge2, glass_insulator_MMM_Unnamed_1, glass_insulator_MMM_Unnamed_13)
  cement2.cover_lines()
  Region [air] = region(+X=60 percentage offset, -X=0mm absolute position, +Y=0 percentage offset, -Y=0 percentage offset, +Z=60 percentage offset, -Z=60 percentage offset)
  group glass_insulator_MMM = glass_insulator_MMM_Unnamed_8, cap, pin, glass, cement1, cement2
mesh:
  initial mesh: MeshMethod=AnsoftTAU
