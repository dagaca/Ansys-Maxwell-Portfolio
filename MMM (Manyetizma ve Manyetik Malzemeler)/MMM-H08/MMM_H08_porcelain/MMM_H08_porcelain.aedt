# Ansys Electronics Desktop project, version 2018.0
materials:
  vacuum: permittivity=1
  porcelain: permittivity=5.7
  steel_1008: permeability{BType=normal HUnit=A_per_meter BUnit=tesla curve (0, 0) (159.2, 0.2402) (318.3, 0.8654) (477.5, 1.1106) (636.6, 1.2458) (795.8, 1.331) (1591.5, 1.5) (3183.1, 1.6) (4774.6, 1.683) (6366.2, 1.741) (7957.7, 1.78) (15915.5, 1.905) (31831, 2.025) (47746.5, 2.085) (63662, 2.13) (79577.5, 2.165) (159155, 2.28) (318310, 2.485) (397887, 2.5851)} conductivity=2000000
  cement: permittivity=2.09 conductivity=10^-14

design Maxwell2DDesign1 (Maxwell 2D, Electrostatic, about Z geometry, model units mm)
geometry:
  porcelain_insulator_Unnamed_1..porcelain_insulator_Unnamed_9 = imported_body(C:\Users\dagac\OneDrive\MasaÃ¼stÃ¼\porcelain_insulator.iges)
  pin [steel_1008] = imported_body(C:\Users\dagac\OneDrive\MasaÃ¼stÃ¼\porcelain_insulator.iges)
  porcelain_insulator_Unnamed_11..porcelain_insulator_Unnamed_14 = imported_body(C:\Users\dagac\OneDrive\MasaÃ¼stÃ¼\porcelain_insulator.iges)
  porcelain [porcelain] = imported_body(C:\Users\dagac\OneDrive\MasaÃ¼stÃ¼\porcelain_insulator.iges)
  porcelain_insulator_Unnamed_16..porcelain_insulator_Unnamed_37 = imported_body(C:\Users\dagac\OneDrive\MasaÃ¼stÃ¼\porcelain_insulator.iges)
  cap [steel_1008] = imported_body(C:\Users\dagac\OneDrive\MasaÃ¼stÃ¼\porcelain_insulator.iges)
  porcelain_insulator_Unnamed_39, porcelain_insulator_Unnamed_40 = imported_body(C:\Users\dagac\OneDrive\MasaÃ¼stÃ¼\porcelain_insulator.iges)
  cap.unite(porcelain_insulator_Unnamed_17, porcelain_insulator_Unnamed_27..porcelain_insulator_Unnamed_30, porcelain_insulator_Unnamed_33, porcelain_insulator_Unnamed_36, porcelain_insulator_Unnamed_39, porcelain_insulator_Unnamed_40)
  cap.cover_lines()
  porcelain.unite(porcelain_insulator_Unnamed_16, porcelain_insulator_Unnamed_13, porcelain_insulator_Unnamed_6)
  porcelain.cover_lines()
  pin.unite(porcelain_insulator_Unnamed_11, porcelain_insulator_Unnamed_5, porcelain_insulator_Unnamed_8, porcelain_insulator_Unnamed_1, porcelain_insulator_Unnamed_4, porcelain_insulator_Unnamed_2)
  pin.cover_lines()
  cement1 [cement] = object_from(?.edge(#77))
  porcelain_insulator_Unnamed_38_ObjectFromEdge1 = object_from(?.edge(#87))
  cement1.unite(porcelain_insulator_Unnamed_38_ObjectFromEdge1, porcelain_insulator_Unnamed_14, porcelain_insulator_Unnamed_18)
  cement1.cover_lines()
  porcelain_insulator_Unnamed_15_ObjectFromEdge2 = object_from(?.edge(#67))
  cement2 [cement], porcelain_insulator_Unnamed_10_ObjectFromEdge1 = object_from(?.edge(#52, #42))
  cement2.unite(porcelain_insulator_Unnamed_15_ObjectFromEdge2, porcelain_insulator_Unnamed_10_ObjectFromEdge1, porcelain_insulator_Unnamed_12, porcelain_insulator_Unnamed_7)
  cement2.cover_lines()
  Region [vacuum] = region(+X=60 percentage offset, -X=0mm absolute position, +Y=0 percentage offset, -Y=0 percentage offset, +Z=60 percentage offset, -Z=60 percentage offset)
  group porcelain_insulator = porcelain_insulator_Unnamed_3, porcelain_insulator_Unnamed_9, pin, porcelain, porcelain_insulator_Unnamed_19..porcelain_insulator_Unnamed_26, porcelain_insulator_Unnamed_31, porcelain_insulator_Unnamed_32, porcelain_insulator_Unnamed_34, porcelain_insulator_Unnamed_35, porcelain_insulator_Unnamed_37, cap, cement1, cement2
mesh:
  initial mesh: MeshMethod=AnsoftTAU
