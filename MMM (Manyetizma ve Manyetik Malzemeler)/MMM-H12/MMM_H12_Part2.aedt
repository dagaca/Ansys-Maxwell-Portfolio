# Ansys Electronics Desktop project, version 2018.0
materials:
  vacuum: permittivity=1
  copper: permeability=0.999991 conductivity=58000000
  cast_iron: permeability=60 conductivity=1500000

design Maxwell3DDesign1 (Maxwell 3D, EddyCurrent, model units cm)
options: Multiplier=1
geometry:
  coil = user_primitive(SegmentedHelix/PolygonHelix.dll, PolygonSegments=4, PolygonRadius=1.5cm, StartHelixRadius=15cm, RadiusChange=3.1cm, Pitch=0cm, Turns=8, SegmentsPerTurn=36, RightHanded=1)
  Box1 = box(corner=(14cm, 0cm, -2cm), size=(2cm, 2cm, -2cm))
  Coil_2 [copper] = box(corner=(40.5cm, 0cm, -2cm), size=(-2cm, -2cm, -2cm))
  Box1_ObjectFromFace1 = object_from(Coil_2.face(6 of 6))
  Box2_ObjectFromFace1 = object_from(Coil_2.face(-x))
  Box1_ObjectFromFace1.connect(Box2_ObjectFromFace1)
  Box2_1 = Coil_2.duplicate_along_line(step=(0cm, 0cm, 1cm), total=2)
  Box1_1 = Box1.duplicate_along_line(step=(0cm, 0cm, 1cm), total=2)
  Coil_2.unite(Box1, coil, Box1_ObjectFromFace1, Box2_1, Box1_1)
  Disk [cast_iron] = polyhedron(axis=Z, centre=(0cm, 0cm, 1.5cm), first_corner=(41cm, 0cm, 1.5cm), sides=36, height=1cm)
  Coil_2_terminal [copper] = Coil_2.section(plane=YZ)
  Coil_2_terminal.separate_bodies()
  Disk_ObjectFromFace1 [cast_iron] = object_from(Disk.face(2 of 38))
  Disk_ObjectFromFace1.move(0cm, 0cm, 125cm)
  Disk_ObjectFromFace1_1 [cast_iron] = Disk_ObjectFromFace1.duplicate_along_line(step=(0cm, 0cm, 0.125cm), total=2)
  region [vacuum] = polyhedron(axis=Z, centre=(0cm, 0cm, -50cm), first_corner=(150cm, 0cm, -50cm), sides=36, height=100cm)
boundaries and excitations:
  Current1: Current Objects=Coil_2_terminal Phase=0deg Current=120A IsSolid=true Point_out_of_terminal=false
  eddy effects on: Disk
mesh:
  initial mesh: GlobalCurvilinear{Apply}
setups:
  Setup1: EddyCurrent MaximumPasses=10 MinimumPasses=2 MinimumConvergedPasses=1 PercentRefinement=20 PercentError=2 NonLinearResidual=0.0001 Frequency=510Hz
field plots:
  Ohmic_Loss1: Ohmic-Loss over Disk on Setup1 : LastAdaptive at Freq=510Hz Phase=0deg
